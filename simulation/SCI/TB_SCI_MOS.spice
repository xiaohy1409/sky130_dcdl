** sch_path: /home/xiaohi/Projects/sky130_dcdl/xschem/schematic/TB_SCI_MOS.sch
**.subckt TB_SCI_MOS
x1 net1 IN OUT 0 net6 net5 net4 net3 net2 SCI_1bit
V1 net2 0 0
V2 net3 0 0
V3 net4 0 0
V4 net5 0 0
V5 net6 0 0
V6 IN 0 PULSE(0 1.8 1n 50p 50p 2n 4n)
V7 net1 0 1.8
**** begin user architecture code

** opencircuitdesign pdks install
.lib /home/xiaohi/.ciel/ciel/sky130/versions/1689ac3f2dc763876eaf967227c7dfe831b031ae/sky130A/libs.tech/combined/sky130.lib.spice tt

.option rshunt=1e12
.tran 2p 25n

.control
save v(IN) v(OUT)

* Output file
echo code t_rise_ps t_fall_ps t_pd_ps > /home/xiaohi/Projects/sky130_dcdl/results/csv/sci5_delay.dat

* Sweep 5-bit: 00000 -> 11111
foreach b4 0 1
 foreach b3 0 1
  foreach b2 0 1
   foreach b1 0 1
    foreach b0 0 1

     * Convert bits to voltage
     let v0 = 1.8 * $b0
     let v1 = 1.8 * $b1
     let v2 = 1.8 * $b2
     let v3 = 1.8 * $b3
     let v4 = 1.8 * $b4

     * Set control voltage
     alter V1 $&v0
     alter V2 $&v1
     alter V3 $&v2
     alter V4 $&v3
     alter V5 $&v4

     * Run transient simulation
     run

     * Measure propagation delay
     meas tran t_rise TRIG v(IN) VAL=0.9 RISE=2 TARG v(OUT) VAL=0.9 RISE=2
     meas tran t_fall TRIG v(IN) VAL=0.9 FALL=2 TARG v(OUT) VAL=0.9 FALL=2

     * Calculate code and delay in ps
     let code = 16 * $b4 + 8 * $b3 + 4 * $b2 + 2 * $b1 + $b0
     let rise_ps = t_rise * 1e12
     let fall_ps = t_fall * 1e12
     let pd_ps = (rise_ps + fall_ps)/2

     * Append result to file
     echo $&code $&rise_ps $&fall_ps $&pd_ps >> /home/xiaohi/Projects/sky130_dcdl/results/csv/sci5_delay.dat

    end
   end
  end
 end
end

echo Sweep completed: 32 codes
.endc

**** end user architecture code
**.ends

* expanding   symbol:  /home/xiaohi/Projects/sky130_dcdl/xschem/schematic/SCI_DCDL/SCI_1bit.sym # of pins=9
** sym_path: /home/xiaohi/Projects/sky130_dcdl/xschem/schematic/SCI_DCDL/SCI_1bit.sym
** sch_path: /home/xiaohi/Projects/sky130_dcdl/xschem/schematic/SCI_DCDL/SCI_1bit.sch
.subckt SCI_1bit VDD IN OUT VSS A4 A3 A2 A1 A0
*.ipin IN
*.opin OUT
*.iopin VDD
*.iopin VSS
*.ipin A4
*.ipin A3
*.ipin A2
*.ipin A1
*.ipin A0
XM1 net1 IN VSS VSS sky130_fd_pr__nfet_01v8 L=0.15 W=2 nf=1 ad=0.58 as=0.58 pd=4.58 ps=4.58 nrd=0.145 nrs=0.145 sa=0 sb=0 sd=0
+ mult=1
XM3 OUT net1 VSS VSS sky130_fd_pr__nfet_01v8 L=0.15 W=1 nf=1 ad=0.29 as=0.29 pd=2.58 ps=2.58 nrd=0.29 nrs=0.29 sa=0 sb=0 sd=0
+ mult=1
XM5 net1 IN VDD VDD sky130_fd_pr__pfet_01v8 L=0.15 W=5 nf=1 ad=1.45 as=1.45 pd=10.58 ps=10.58 nrd=0.058 nrs=0.058 sa=0 sb=0 sd=0
+ mult=1
XM2 OUT net1 VDD VDD sky130_fd_pr__pfet_01v8 L=0.15 W=2.5 nf=1 ad=0.725 as=0.725 pd=5.58 ps=5.58 nrd=0.116 nrs=0.116 sa=0 sb=0
+ sd=0 mult=1
XM4 net1 A4 net2 VSS sky130_fd_pr__nfet_01v8 L=0.15 W=0.42 nf=1 ad=0.1218 as=0.1218 pd=1.42 ps=1.42 nrd=0.69047619047619
+ nrs=0.69047619047619 sa=0 sb=0 sd=0 mult=1
XM6 net1 A3 net3 VSS sky130_fd_pr__nfet_01v8 L=0.15 W=0.42 nf=1 ad=0.1218 as=0.1218 pd=1.42 ps=1.42 nrd=0.69047619047619
+ nrs=0.69047619047619 sa=0 sb=0 sd=0 mult=1
XM7 net1 A2 net4 VSS sky130_fd_pr__nfet_01v8 L=0.15 W=0.42 nf=1 ad=0.1218 as=0.1218 pd=1.42 ps=1.42 nrd=0.69047619047619
+ nrs=0.69047619047619 sa=0 sb=0 sd=0 mult=1
XM8 net1 A1 net5 VSS sky130_fd_pr__nfet_01v8 L=0.15 W=0.42 nf=1 ad=0.1218 as=0.1218 pd=1.42 ps=1.42 nrd=0.69047619047619
+ nrs=0.69047619047619 sa=0 sb=0 sd=0 mult=1
XM9 net1 A0 net6 VSS sky130_fd_pr__nfet_01v8 L=0.15 W=0.42 nf=1 ad=0.1218 as=0.1218 pd=1.42 ps=1.42 nrd=0.69047619047619
+ nrs=0.69047619047619 sa=0 sb=0 sd=0 mult=1
XM10 VSS net2 VSS VSS sky130_fd_pr__nfet_01v8 L=0.15 W=8 nf=1 ad=2.32 as=2.32 pd=16.58 ps=16.58 nrd=0.03625 nrs=0.03625 sa=0 sb=0
+ sd=0 mult=1
XM11 net7 net3 net7 net7 sky130_fd_pr__nfet_01v8 L=0.15 W=4 nf=1 ad=1.16 as=1.16 pd=8.58 ps=8.58 nrd=0.0725 nrs=0.0725 sa=0 sb=0
+ sd=0 mult=1
XM12 VSS net4 VSS VSS sky130_fd_pr__nfet_01v8 L=0.15 W=2 nf=1 ad=0.58 as=0.58 pd=4.58 ps=4.58 nrd=0.145 nrs=0.145 sa=0 sb=0 sd=0
+ mult=1
XM13 VSS net5 VSS VSS sky130_fd_pr__nfet_01v8 L=0.15 W=1 nf=1 ad=0.29 as=0.29 pd=2.58 ps=2.58 nrd=0.29 nrs=0.29 sa=0 sb=0 sd=0
+ mult=1
XM14 VSS net6 VSS VSS sky130_fd_pr__nfet_01v8 L=0.15 W=0.5 nf=1 ad=0.145 as=0.145 pd=1.58 ps=1.58 nrd=0.58 nrs=0.58 sa=0 sb=0 sd=0
+ mult=1
.ends

.end
