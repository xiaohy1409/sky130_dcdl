** sch_path: /home/xiaohi/Projects/sky130_dcdl/xschem/schematic/SCI_DCDL/TG_SCI/TB_TG1BIT.sch
**.subckt TB_TG1BIT
x1 net2 IN OUT 0 net1 SCI_1bit
V1 net1 0 0
V2 IN 0 PULSE(0 1.8 1n 50p 50p 2n 4n)
V3 net2 0 1.8
**** begin user architecture code

.param WTG=0.5
.option rshunt=1e12
.tran 1p 25n 0 1p

.control

* Output file
echo W_um t_off_ps t_on_ps delta_ps > /home/xiaohi/Projects/sky130_dcdl/results/csv/tg_sizing.dat

* Sweep transistor width in um
foreach w 0.5 1 2 4 8

  alterparam WTG = $w
  reset
  save v(IN) v(OUT)

  * TG OFF
  alter V1 dc = 0
  run

  meas tran tr_off TRIG v(IN) VAL=0.9 RISE=2 TARG v(OUT) VAL=0.9 RISE=2
  meas tran tf_off TRIG v(IN) VAL=0.9 FALL=2 TARG v(OUT) VAL=0.9 FALL=2

  let td_off = (tr_off + tf_off)*0.5e12
  set delay_off = $&td_off

  * TG ON
  alter V1 dc = 1.8
  run

  meas tran tr_on TRIG v(IN) VAL=0.9 RISE=2 TARG v(OUT) VAL=0.9 RISE=2
  meas tran tf_on TRIG v(IN) VAL=0.9 FALL=2 TARG v(OUT) VAL=0.9 FALL=2

  let td_on = (tr_on + tf_on)*0.5e12
  set delay_on = $&td_on

  * Calculate incremental delay
  setplot const
  let delta = $delay_on - $delay_off

  echo $w $delay_off $delay_on $&delta >> /home/xiaohi/Projects/sky130_dcdl/results/csv/tg_sizing.dat

end

echo TG sizing sweep completed
.endc

** opencircuitdesign pdks install
.lib /home/xiaohi/.ciel/ciel/sky130/versions/1689ac3f2dc763876eaf967227c7dfe831b031ae/sky130A/libs.tech/combined/sky130.lib.spice tt

**** end user architecture code
**.ends

* expanding   symbol:  SCI_1bit.sym # of pins=5
** sym_path: /home/xiaohi/Projects/sky130_dcdl/xschem/schematic/SCI_DCDL/TG_SCI/SCI_1bit.sym
** sch_path: /home/xiaohi/Projects/sky130_dcdl/xschem/schematic/SCI_DCDL/TG_SCI/SCI_1bit.sch
.subckt SCI_1bit VDD IN OUT VSS A0
*.ipin IN
*.opin OUT
*.iopin VDD
*.iopin VSS
*.ipin A0
XM1 net1 IN VSS VSS sky130_fd_pr__nfet_01v8 L=0.15 W=1 nf=1 ad=0.29 as=0.29 pd=2.58 ps=2.58 nrd=0.29 nrs=0.29 sa=0 sb=0 sd=0
+ mult=1
XM3 OUT net1 VSS VSS sky130_fd_pr__nfet_01v8 L=0.15 W=1 nf=1 ad=0.29 as=0.29 pd=2.58 ps=2.58 nrd=0.29 nrs=0.29 sa=0 sb=0 sd=0
+ mult=1
XM5 net1 IN VDD VDD sky130_fd_pr__pfet_01v8 L=0.15 W=2.5 nf=1 ad=0.725 as=0.725 pd=5.58 ps=5.58 nrd=0.116 nrs=0.116 sa=0 sb=0 sd=0
+ mult=1
XM2 OUT net1 VDD VDD sky130_fd_pr__pfet_01v8 L=0.15 W=2.5 nf=1 ad=0.725 as=0.725 pd=5.58 ps=5.58 nrd=0.116 nrs=0.116 sa=0 sb=0
+ sd=0 mult=1
XM4 net1 A0 net2 VSS sky130_fd_pr__nfet_01v8 L=0.15 W={WTG} nf=1 ad='int((1 + 1)/2) * {WTG} / 1 * 0.29' as='int((1 + 2)/2) * {WTG} / 1 * 0.29'
+ pd='2*int((1 + 1)/2) * ({WTG} / 1 + 0.29)' ps='2*int((1 + 2)/2) * ({WTG} / 1 + 0.29)' nrd='0.29 / {WTG} ' nrs='0.29 / {WTG} ' sa=0
+ sb=0 sd=0 mult=1
XM10 net1 net3 net2 VDD sky130_fd_pr__pfet_01v8 L=0.15 W={WTG} nf=1 ad='int((1 + 1)/2) * {WTG} / 1 * 0.29' as='int((1 + 2)/2) * {WTG} / 1 * 0.29'
+ pd='2*int((1 + 1)/2) * ({WTG} / 1 + 0.29)' ps='2*int((1 + 2)/2) * ({WTG} / 1 + 0.29)' nrd='0.29 / {WTG} ' nrs='0.29 / {WTG} ' sa=0
+ sb=0 sd=0 mult=1
x1 A0 VGND VNB VPB VPWR net3 sky130_fd_sc_hd__inv_1
.ends

.end
